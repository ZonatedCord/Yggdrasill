* BaseChipOnly - LED data line: GPIO13 -> R5 -> USBLC6 -> J2 -> 9 leaves in parallel
* Each leaf: wire through the trunk (0.3 m or 0.6 m, ~0.8 uH/m, ~50 pF/m) + WS2812B DIN (~10 pF)
* A: R5 470R 0.3 m  B: R5 470R 0.6 m  C: R5 100R 0.3 m  D: R5 100R 0.6 m
VGPIO g 0 PWL(0 0 5e-07 0 5.02e-07 3.3 9e-07 3.3 9.02e-07 0 1.75e-06 0 1.752e-06 3.3 2.55e-06 3.3 2.552e-06 0 3e-06 0 3.002e-06 3.3 3.4e-06 3.3 3.402e-06 0 4.25e-06 0 4.252e-06 3.3 5.05e-06 3.3 5.052e-06 0 5.5e-06 0 5.502e-06 3.3 6.3e-06 3.3 6.302e-06 0 6.75e-06 0 6.752e-06 3.3 7.15e-06 3.3 7.152e-06 0 9e-06 0)
RdrvA g dA 30
R5A dA uA 470
CU3A uA 0 3.5p
CwA0a uA 0 7.5e-12
LwA0 uA wA0 2.4e-07
RwA0 wA0 xA0 0.05
CwA0b xA0 0 7.5e-12
CdinA0 xA0 0 10p
CwA1a uA 0 7.5e-12
LwA1 uA wA1 2.4e-07
RwA1 wA1 xA1 0.05
CwA1b xA1 0 7.5e-12
CdinA1 xA1 0 10p
CwA2a uA 0 7.5e-12
LwA2 uA wA2 2.4e-07
RwA2 wA2 xA2 0.05
CwA2b xA2 0 7.5e-12
CdinA2 xA2 0 10p
CwA3a uA 0 7.5e-12
LwA3 uA wA3 2.4e-07
RwA3 wA3 xA3 0.05
CwA3b xA3 0 7.5e-12
CdinA3 xA3 0 10p
CwA4a uA 0 7.5e-12
LwA4 uA wA4 2.4e-07
RwA4 wA4 xA4 0.05
CwA4b xA4 0 7.5e-12
CdinA4 xA4 0 10p
CwA5a uA 0 7.5e-12
LwA5 uA wA5 2.4e-07
RwA5 wA5 xA5 0.05
CwA5b xA5 0 7.5e-12
CdinA5 xA5 0 10p
CwA6a uA 0 7.5e-12
LwA6 uA wA6 2.4e-07
RwA6 wA6 xA6 0.05
CwA6b xA6 0 7.5e-12
CdinA6 xA6 0 10p
CwA7a uA 0 7.5e-12
LwA7 uA wA7 2.4e-07
RwA7 wA7 xA7 0.05
CwA7b xA7 0 7.5e-12
CdinA7 xA7 0 10p
CwA8a uA 0 7.5e-12
LwA8 uA wA8 2.4e-07
RwA8 wA8 xA8 0.05
CwA8b xA8 0 7.5e-12
CdinA8 xA8 0 10p
RdrvB g dB 30
R5B dB uB 470
CU3B uB 0 3.5p
CwB0a uB 0 1.5e-11
LwB0 uB wB0 4.8e-07
RwB0 wB0 xB0 0.05
CwB0b xB0 0 1.5e-11
CdinB0 xB0 0 10p
CwB1a uB 0 1.5e-11
LwB1 uB wB1 4.8e-07
RwB1 wB1 xB1 0.05
CwB1b xB1 0 1.5e-11
CdinB1 xB1 0 10p
CwB2a uB 0 1.5e-11
LwB2 uB wB2 4.8e-07
RwB2 wB2 xB2 0.05
CwB2b xB2 0 1.5e-11
CdinB2 xB2 0 10p
CwB3a uB 0 1.5e-11
LwB3 uB wB3 4.8e-07
RwB3 wB3 xB3 0.05
CwB3b xB3 0 1.5e-11
CdinB3 xB3 0 10p
CwB4a uB 0 1.5e-11
LwB4 uB wB4 4.8e-07
RwB4 wB4 xB4 0.05
CwB4b xB4 0 1.5e-11
CdinB4 xB4 0 10p
CwB5a uB 0 1.5e-11
LwB5 uB wB5 4.8e-07
RwB5 wB5 xB5 0.05
CwB5b xB5 0 1.5e-11
CdinB5 xB5 0 10p
CwB6a uB 0 1.5e-11
LwB6 uB wB6 4.8e-07
RwB6 wB6 xB6 0.05
CwB6b xB6 0 1.5e-11
CdinB6 xB6 0 10p
CwB7a uB 0 1.5e-11
LwB7 uB wB7 4.8e-07
RwB7 wB7 xB7 0.05
CwB7b xB7 0 1.5e-11
CdinB7 xB7 0 10p
CwB8a uB 0 1.5e-11
LwB8 uB wB8 4.8e-07
RwB8 wB8 xB8 0.05
CwB8b xB8 0 1.5e-11
CdinB8 xB8 0 10p
RdrvC g dC 30
R5C dC uC 100
CU3C uC 0 3.5p
CwC0a uC 0 7.5e-12
LwC0 uC wC0 2.4e-07
RwC0 wC0 xC0 0.05
CwC0b xC0 0 7.5e-12
CdinC0 xC0 0 10p
CwC1a uC 0 7.5e-12
LwC1 uC wC1 2.4e-07
RwC1 wC1 xC1 0.05
CwC1b xC1 0 7.5e-12
CdinC1 xC1 0 10p
CwC2a uC 0 7.5e-12
LwC2 uC wC2 2.4e-07
RwC2 wC2 xC2 0.05
CwC2b xC2 0 7.5e-12
CdinC2 xC2 0 10p
CwC3a uC 0 7.5e-12
LwC3 uC wC3 2.4e-07
RwC3 wC3 xC3 0.05
CwC3b xC3 0 7.5e-12
CdinC3 xC3 0 10p
CwC4a uC 0 7.5e-12
LwC4 uC wC4 2.4e-07
RwC4 wC4 xC4 0.05
CwC4b xC4 0 7.5e-12
CdinC4 xC4 0 10p
CwC5a uC 0 7.5e-12
LwC5 uC wC5 2.4e-07
RwC5 wC5 xC5 0.05
CwC5b xC5 0 7.5e-12
CdinC5 xC5 0 10p
CwC6a uC 0 7.5e-12
LwC6 uC wC6 2.4e-07
RwC6 wC6 xC6 0.05
CwC6b xC6 0 7.5e-12
CdinC6 xC6 0 10p
CwC7a uC 0 7.5e-12
LwC7 uC wC7 2.4e-07
RwC7 wC7 xC7 0.05
CwC7b xC7 0 7.5e-12
CdinC7 xC7 0 10p
CwC8a uC 0 7.5e-12
LwC8 uC wC8 2.4e-07
RwC8 wC8 xC8 0.05
CwC8b xC8 0 7.5e-12
CdinC8 xC8 0 10p
RdrvD g dD 30
R5D dD uD 100
CU3D uD 0 3.5p
CwD0a uD 0 1.5e-11
LwD0 uD wD0 4.8e-07
RwD0 wD0 xD0 0.05
CwD0b xD0 0 1.5e-11
CdinD0 xD0 0 10p
CwD1a uD 0 1.5e-11
LwD1 uD wD1 4.8e-07
RwD1 wD1 xD1 0.05
CwD1b xD1 0 1.5e-11
CdinD1 xD1 0 10p
CwD2a uD 0 1.5e-11
LwD2 uD wD2 4.8e-07
RwD2 wD2 xD2 0.05
CwD2b xD2 0 1.5e-11
CdinD2 xD2 0 10p
CwD3a uD 0 1.5e-11
LwD3 uD wD3 4.8e-07
RwD3 wD3 xD3 0.05
CwD3b xD3 0 1.5e-11
CdinD3 xD3 0 10p
CwD4a uD 0 1.5e-11
LwD4 uD wD4 4.8e-07
RwD4 wD4 xD4 0.05
CwD4b xD4 0 1.5e-11
CdinD4 xD4 0 10p
CwD5a uD 0 1.5e-11
LwD5 uD wD5 4.8e-07
RwD5 wD5 xD5 0.05
CwD5b xD5 0 1.5e-11
CdinD5 xD5 0 10p
CwD6a uD 0 1.5e-11
LwD6 uD wD6 4.8e-07
RwD6 wD6 xD6 0.05
CwD6b xD6 0 1.5e-11
CdinD6 xD6 0 10p
CwD7a uD 0 1.5e-11
LwD7 uD wD7 4.8e-07
RwD7 wD7 xD7 0.05
CwD7b xD7 0 1.5e-11
CdinD7 xD7 0 10p
CwD8a uD 0 1.5e-11
LwD8 uD wD8 4.8e-07
RwD8 wD8 xD8 0.05
CwD8b xD8 0 1.5e-11
CdinD8 xD8 0 10p
.control
tran 0.5n 9u
wrdata out/05_dataline.dat v(g) v(xA0) v(xB0) v(xC0) v(xD0)
meas tran trA_25 WHEN v(xA0)=2.5 RISE=1
meas tran vmaxA MAX v(xA0) from=0.5u to=0.9u
meas tran trB_25 WHEN v(xB0)=2.5 RISE=1
meas tran vmaxB MAX v(xB0) from=0.5u to=0.9u
meas tran trC_25 WHEN v(xC0)=2.5 RISE=1
meas tran vmaxC MAX v(xC0) from=0.5u to=0.9u
meas tran trD_25 WHEN v(xD0)=2.5 RISE=1
meas tran vmaxD MAX v(xD0) from=0.5u to=0.9u
meas tran tsrc WHEN v(g)=1.65 RISE=1
quit
.endc
.end
